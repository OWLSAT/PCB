# Ansys Electronics Desktop project, version 2021.2
materials:
  vacuum: permittivity=1
  copper: permeability=0.999991 conductivity=58000000
  FR4_epoxy: permittivity=4.4 dielectric_loss_tangent=0.02
  aluminum: permeability=1.000021 conductivity=38000000
  steel_stainless: conductivity=1100000
  PMLGroup1_Z_1: permittivity{anisotropic component1=1.1 component2=1.1 component3=0.45454545} permeability{anisotropic component1=1.1 component2=1.1 component3=0.45454545} dielectric_loss_tangent{anisotropic component1=1 component2=1 component3=-1} magnetic_loss_tangent{anisotropic component1=1 component2=1 component3=-1}
  PMLGroup1_XZ_1: permittivity{anisotropic component1=1 component2=0.01 component3=1} permeability{anisotropic component1=1 component2=0.01 component3=1} dielectric_loss_tangent{anisotropic component1=0 component2=242 component3=0} magnetic_loss_tangent{anisotropic component1=0 component2=242 component3=0}
  PMLGroup1_YZ_1: permittivity{anisotropic component1=0.01 component2=1 component3=1} permeability{anisotropic component1=0.01 component2=1 component3=1} dielectric_loss_tangent{anisotropic component1=242 component2=0 component3=0} magnetic_loss_tangent{anisotropic component1=242 component2=0 component3=0}
  PMLGroup1_XYZ_1: permittivity{anisotropic component1=1.1 component2=1.1 component3=1.1} permeability{anisotropic component1=1.1 component2=1.1 component3=1.1} dielectric_loss_tangent{anisotropic component1=1 component2=1 component3=1} magnetic_loss_tangent{anisotropic component1=1 component2=1 component3=1}

design HFSSDesign1 (HFSS, DrivenModal, model units mm)
variables:
  l = 163.7mm
geometry:
  plane Plane1 = base (0mm, 0.5mm, 0mm) normal (0mm, -0.5mm, 0mm)
  Box1 [aluminum] = imported_body()
  Box2 [FR4_epoxy] = imported_body()
  Box3 [aluminum] = box(corner=(0mm, 0mm, 0mm), size=(12.5mm, l, 0.07mm))
  Box3.move(0mm, (79/2) mm, 0mm)
  Box4 [aluminum] = box(corner=(0mm, 0mm, 0mm), size=(12.5mm, l, 0.07mm))
  Box4.move(0mm, (79/2) mm, 0mm)
  Box4.mirror(point=(0mm, 0mm, 0mm), normal=(0mm, (-79/2) mm, 0mm))
  [Box3, Box4].move((-12.5/2) mm, 0mm, 0mm)
  Box5 [aluminum] = box(corner=(0mm, 0mm, 0mm), size=(12.5mm, l, 0.07mm))
  Box5.move(0mm, (79/2) mm, 0mm)
  Box5.move((-12.5/2) mm, 0mm, 0mm)
  Box6 [aluminum] = box(corner=(0mm, 0mm, 0mm), size=(12.5mm, l, 0.07mm))
  Box6.move(0mm, (79/2) mm, 0mm)
  Box6.mirror(point=(0mm, 0mm, 0mm), normal=(0mm, (-79/2) mm, 0mm))
  Box6.move((-12.5/2) mm, 0mm, 0mm)
  [Box5, Box6].rotate(axis=Z, angle=90deg)
  [Box3..Box6].move(0mm, 0mm, -0.07mm)
  RadiatingSurface [vacuum] = region(absolute_offset=171.63453mm on all sides)
  coordinate_system FaceCS1 = face of RadiatingSurface: Origin=RadiatingSurface.vertex(1 of 8) FaceID=RadiatingSurface.face(+z) AxisPosn=RadiatingSurface.vertex(2 of 8) WhichAxis=X ZRotationAngle=0deg XOffset=0mm YOffset=0mm
  coordinate_system FaceCS2 = face of RadiatingSurface: Origin=RadiatingSurface.vertex(5 of 8) FaceID=RadiatingSurface.face(-z) AxisPosn=RadiatingSurface.vertex(6 of 8) WhichAxis=X ZRotationAngle=0deg XOffset=0mm YOffset=0mm
  coordinate_system FaceCS3 = face of RadiatingSurface: Origin=RadiatingSurface.vertex(4 of 8) FaceID=RadiatingSurface.face(-y) AxisPosn=RadiatingSurface.vertex(7 of 8) WhichAxis=X ZRotationAngle=0deg XOffset=0mm YOffset=0mm
  coordinate_system FaceCS4 = face of RadiatingSurface: Origin=RadiatingSurface.vertex(3 of 8) FaceID=RadiatingSurface.face(-x) AxisPosn=RadiatingSurface.vertex(8 of 8) WhichAxis=X ZRotationAngle=0deg XOffset=0mm YOffset=0mm
  coordinate_system FaceCS5 = face of RadiatingSurface: Origin=RadiatingSurface.vertex(2 of 8) FaceID=RadiatingSurface.face(+y) AxisPosn=RadiatingSurface.vertex(5 of 8) WhichAxis=X ZRotationAngle=0deg XOffset=0mm YOffset=0mm
  coordinate_system FaceCS6 = face of RadiatingSurface: Origin=RadiatingSurface.vertex(1 of 8) FaceID=RadiatingSurface.face(+x) AxisPosn=RadiatingSurface.vertex(6 of 8) WhichAxis=X ZRotationAngle=0deg XOffset=0mm YOffset=0mm
  coordinate_system FaceCS7 = face of RadiatingSurface: Origin=RadiatingSurface.vertex(6 of 8) FaceID=RadiatingSurface.face(-z) AxisPosn=RadiatingSurface.vertex(7 of 8) WhichAxis=X ZRotationAngle=0deg XOffset=0mm YOffset=0mm
  coordinate_system FaceCS8 = face of RadiatingSurface: Origin=RadiatingSurface.vertex(7 of 8) FaceID=RadiatingSurface.face(-z) AxisPosn=RadiatingSurface.vertex(8 of 8) WhichAxis=X ZRotationAngle=0deg XOffset=0mm YOffset=0mm
  coordinate_system FaceCS9 = face of RadiatingSurface: Origin=RadiatingSurface.vertex(8 of 8) FaceID=RadiatingSurface.face(-z) AxisPosn=RadiatingSurface.vertex(5 of 8) WhichAxis=X ZRotationAngle=0deg XOffset=0mm YOffset=0mm
boundaries and excitations:
  Rad1: Radiation Objects=RadiatingSurface
  1: Lumped Port Faces=Box6.face(3 of 6) Modes{Mode1{IntLine{middle of Box6.edge(4 of 12) -> middle of Box6.edge(6 of 12)} CharImp=Zpi RenormImp=50ohm}} Impedance=50ohm
  2: Lumped Port Faces=Box4.face(3 of 6) Modes{Mode1{IntLine{middle of Box4.edge(4 of 12) -> middle of Box4.edge(6 of 12)} CharImp=Zpi RenormImp=50ohm}} Impedance=50ohm
  3: Lumped Port Faces=Box5.face(3 of 6) Modes{Mode1{IntLine{middle of Box5.edge(4 of 12) -> middle of Box5.edge(6 of 12)} CharImp=Zpi RenormImp=50ohm}} Impedance=50ohm
  4: Lumped Port Faces=Box3.face(-y) Modes{Mode1{IntLine{middle of Box3.edge(4 of 12) -> middle of Box3.edge(6 of 12)} CharImp=Zpi RenormImp=50ohm}} Impedance=50ohm
setups:
  Setup1: HfssDriven Frequency=436.975MHz MaxDeltaS=0.02 MaximumPasses=6 MinimumPasses=1 MinimumConvergedPasses=1 PercentRefinement=30 BasisOrder=1 PortAccuracy=2 VariablesForDerivatives(l) VariableFlagsForDerivatives(1)
    sweep Sweep: 218.4875MHz to 655.4625MHz, 401 points; Type=Interpolating SaveFields InterpTolerance=0.5 InterpMaxSolns=250 InterpUsePortImped=false PassivityErrorTolerance=0.0001
source amplitudes:
  1:1: 1W 0deg
  2:1: 1W 90deg
  3:1: 1W 180deg
  4:1: 1W 270deg
optimetrics:
  ParametricSetup1: Parametric Sim._Setups=[Setup1]
    sweep l: LIN 116mm 170mm 4mm
  ParametricSetup2: Parametric Sim._Setups=[Setup1]
    sweep l: LIN 112mm 170mm 4mm
radiation setups:
  Infinite Sphere1: Infinite Sphere Theta=-180deg..180deg step 2deg Phi=0deg..360deg step 2deg
reports:
  rE Plot 1: dB(rETotal) vs Theta on Setup1 : LastAdaptive, Infinite Sphere1 [Phi=0deg Freq=0.436975GHz]; markers m1 at 180deg
  rE Plot 2: dB(rETotal) vs Phi, Theta on Setup1 : LastAdaptive, Infinite Sphere1 [Freq=0.436975GHz l=132mm]
  rE Plot 3: dB(rETotal) vs Theta on Setup1 : LastAdaptive, Infinite Sphere1 [Phi=0deg Freq=0.436975GHz l=163.7mm]
